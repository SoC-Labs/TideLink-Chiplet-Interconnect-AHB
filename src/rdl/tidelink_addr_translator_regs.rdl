// -----------------------------------------------------------------------------
// SoCLabs TideLink Address Translator Register Description (SystemRDL 2.0)
//
// Describes the APB register map for a single channel of the
// tidelink_addr_translator module using CAM-based rule matching.
// Each channel has a base offset register, a global enable control,
// and N programmable match/replace rules (default N=8).
//
// The address translator has up to two independent channels. This addrmap
// describes one channel; instantiate twice at the integration level.
//
// A joint work commissioned on behalf of SoC Labs, under Arm Academic Access license.
//
// Contributors
//   David Mapstone (d.a.mapstone@soton.ac.uk)
//
// Copyright 2026, SoC Labs (www.soclabs.org)
// -----------------------------------------------------------------------------

addrmap tidelink_addr_translator_regs {
    name = "TideLink Address Translator Register Map (CAM-based)";
    desc = "Per-channel address translation configuration using CAM-based
            rule matching. The translator remaps AHB addresses by:
            1. Subtracting base_offset from the input address to normalise it.
            2. Comparing the upper 8 bits (addr[31:24]) of the normalised
               address against each enabled rule's match byte.
            3. If a rule matches, replacing addr[31:24] with the rule's
               replace byte. Lowest-index rule has highest priority.
            4. If no rule matches and global_enable is set, addr[31:24]
               passes through unchanged (identity mapping).
            5. If global_enable is cleared, all addresses pass through
               unchanged regardless of rule state.
            6. addr[23:0] always passes through unchanged.

            On reset all rules are disabled and global_enable is 0,
            giving pure identity passthrough (safe default).";

    default hw = r;
    default sw = r;
    default reset = 0;

    // =========================================================================
    // Base Offset Register
    // =========================================================================

    reg base_offset_reg {
        name = "Base Offset";
        desc = "32-bit value subtracted from the input AHB address before the
                upper-byte rule matching. This allows the translator to operate
                on addresses relative to an arbitrary base.

                For example, if the local AHB slave decodes 0x60000000-0x6FFFFFFF
                for remote access, set base_offset = 0x60000000 so that the
                rule matching sees normalised addresses 0x00000000-0x0FFFFFFF.";

        field {} base_offset[32] = 0;
        base_offset->sw = rw;
        base_offset->hw = r;
    };
    base_offset_reg base_offset @ 0x000;

    // =========================================================================
    // Control Register
    // =========================================================================

    reg ctrl_reg {
        name = "Control";
        desc = "Global translation control. When enable is 0, all addresses
                pass through unchanged regardless of rule configuration.
                When enable is 1, address translation is active and rules
                are evaluated.";

        field {} enable[1] = 0;
        enable->sw = rw;
        enable->hw = r;
        enable->desc = "Global translation enable. 0=identity passthrough, 1=active.";
    };
    ctrl_reg ctrl @ 0x004;

    // =========================================================================
    // Rule Registers (N rules, default 8, at offsets 0x010-0x02C)
    //
    // Each rule register contains:
    //   [0]     — enable: rule active when set
    //   [7:1]   — reserved
    //   [15:8]  — match: upper address byte value to match against
    //   [23:16] — replace: replacement value for upper address byte
    //   [31:24] — reserved
    //
    // Priority: Rule 0 has highest priority. If multiple rules match,
    // the lowest-index rule's replace value is used.
    //
    // Reset: All rules disabled (enable=0, match=0, replace=0).
    // =========================================================================

    reg rule_reg {
        name = "Translation Rule";
        desc = "Programmable address translation rule. When enabled, if the
                normalised input address upper byte matches the match field,
                it is replaced with the replace field in the output address.";

        field {} enable[1] = 0;
        enable->sw = rw;
        enable->hw = r;
        enable->desc = "Rule enable. 0=inactive, 1=active.";

        field {} rsvd_0[7] = 0;
        rsvd_0->sw = r;
        rsvd_0->hw = na;
        rsvd_0->desc = "Reserved.";

        field {} match_byte[8] = 0;
        match_byte->sw = rw;
        match_byte->hw = r;
        match_byte->desc = "Upper address byte value to match against (addr_norm[31:24]).";

        field {} replace_byte[8] = 0;
        replace_byte->sw = rw;
        replace_byte->hw = r;
        replace_byte->desc = "Replacement value for upper address byte when rule matches.";

        field {} rsvd_1[8] = 0;
        rsvd_1->sw = r;
        rsvd_1->hw = na;
        rsvd_1->desc = "Reserved.";
    };

    // Instantiate 8 rule registers at offsets 0x010 through 0x02C
    rule_reg rule[8] @ 0x010 += 0x004;

    // =========================================================================
    // PrimeCell Identification Registers (read-only, fixed values)
    //
    // These follow the ARM PrimeCell convention for peripheral identification.
    // =========================================================================

    reg pidr_reg {
        name = "Peripheral ID Register";
        desc = "Read-only ARM PrimeCell peripheral identification.";

        field {} pid[8] = 0;
        pid->sw = r;
        pid->hw = na;
    };

    reg cidr_reg {
        name = "Component ID Register";
        desc = "Read-only ARM PrimeCell component identification.";

        field {} cid[8] = 0;
        cid->sw = r;
        cid->hw = na;
    };

    pidr_reg pidr4 @ 0xFD0;
    pidr4.pid->reset = 0x00;

    pidr_reg pidr5 @ 0xFD4;
    pidr5.pid->reset = 0x00;

    pidr_reg pidr6 @ 0xFD8;
    pidr6.pid->reset = 0x00;

    pidr_reg pidr7 @ 0xFDC;
    pidr7.pid->reset = 0x00;

    pidr_reg pidr0 @ 0xFE0;
    pidr0.pid->reset = 0x59;

    pidr_reg pidr1 @ 0xFE4;
    pidr1.pid->reset = 0x16;

    pidr_reg pidr2 @ 0xFE8;
    pidr2.pid->reset = 0x15;

    pidr_reg pidr3 @ 0xFEC;
    pidr3.pid->reset = 0x00;

    cidr_reg cidr0 @ 0xFF0;
    cidr0.cid->reset = 0x50;

    cidr_reg cidr1 @ 0xFF4;
    cidr1.cid->reset = 0x51;

    cidr_reg cidr2 @ 0xFF8;
    cidr2.cid->reset = 0x4C;

    cidr_reg cidr3 @ 0xFFC;
    cidr3.cid->reset = 0x54;
};
