// -----------------------------------------------------------------------------
// SoCLabs TideLink Register Description (SystemRDL 2.0)
//
// Describes the APB register map for the tidelink_apb_regs module.
// A joint work commissioned on behalf of SoC Labs, under Arm Academic Access license.
//
// Contributors
//   David Mapstone (d.a.mapstone@soton.ac.uk)
//
// Copyright 2026, SoC Labs (www.soclabs.org)
// -----------------------------------------------------------------------------

addrmap tidelink_regs #(longint unsigned TIDELINK_PAIR_BASE = 0) {
    name = "TideLink APB Register Map";
    desc = "Configuration, status, and credit-flow registers for a single
            TideLink instance. The address space is split into two regions:
            Region 0 (offsets 0x000-0x01F) for configuration and status,
            Region 1 (offsets 0x020-0x03F) for incoming credit receivers.";

    default hw = r;
    default sw = r;
    default reset = 0;

    // =========================================================================
    // Region 0: Configuration and Status (paddr[5] = 0)
    // =========================================================================

    reg pair_base_addr_reg {
        name = "Pair Base Address";
        desc = "Base address of the paired TideLink's APB register space.
                Initialised from the TIDELINK_PAIR_BASE parameter at reset.
                Software may override this at runtime before enabling the block.
                The returner derives its target addresses from this value.";

        field {} pair_base[32] = TIDELINK_PAIR_BASE;
        pair_base->sw = rw;
        pair_base->hw = r;
    };
    pair_base_addr_reg pair_base_addr @ 0x000;

    reg release_threshold_reg {
        name = "Release Threshold";
        desc = "Minimum number of credits to accumulate before the returner fires
                a release-credits packet to the paired TideLink. Reduces AHB master
                bus traffic for workloads with many small packets.
                A value of 0 means release immediately on every read completion
                (backward-compatible with pre-threshold behaviour). Default: 20.";

        field {} threshold[32] = 20;
        threshold->sw = rw;
        threshold->hw = r;
    };
    release_threshold_reg release_threshold @ 0x004;

    reg packet_word_length_reg {
        name = "Packet Word Length";
        desc = "Read-only sideband from the FIFO controller. Shows the word
                length of the packet currently being processed (0 when idle).";

        field {} pkt_word_len[14] = 0;
        pkt_word_len->sw = r;
        pkt_word_len->hw = w;
    };
    packet_word_length_reg packet_word_length @ 0x008;

    reg credit_count_reg {
        name = "Credit Count";
        desc = "Read-only current count of free credits in this TideLink's FIFO.
                Starts at MAX_CREDITS after reset, decremented by writes,
                incremented by reads.";

        field {} count[13] = 0;
        count->sw = r;
        count->hw = w;
    };
    credit_count_reg credit_count @ 0x00C;

    reg status_reg {
        name = "Status Register";
        desc = "Read-only status and sticky fault flags.";

        field {} returner_busy[1] = 0;
        returner_busy->sw = r;
        returner_busy->hw = w;
        returner_busy->desc = "1 when the AHB returner master is mid-transfer.";

        field {} overrun[1] = 0;
        overrun->sw = r;
        overrun->hw = w;
        overrun->desc = "Sticky. Set when a data window write is discarded because
                         the buffer is full (credit count == 0). Cleared by FLUSH.";

        field {} underrun[1] = 0;
        underrun->sw = r;
        underrun->hw = w;
        underrun->desc = "Sticky. Set when a data window read occurs with no packet
                         available (buffer empty). Cleared by FLUSH.";

        field {} master_error[1] = 0;
        master_error->sw = r;
        master_error->hw = w;
        master_error->desc = "Sticky. Set when the AHB master port receives an ERROR
                             response. Cleared by FLUSH.";

        field {} packet_committed[1] = 0;
        packet_committed->sw = r;
        packet_committed->hw = w;
        packet_committed->desc = "Set when a packet has been fully written to the FIFO
                                  (write_complete). Cleared when the receiver reads FIFO
                                  address 0. Mirrors the packet_committed_irq output and
                                  can be polled as an alternative to using the interrupt.";
    };
    status_reg status @ 0x010;

    reg doorbell_reg {
        name = "Doorbell Register";
        desc = "Write-only, self-clearing. Writing any value triggers the
                doorbell mechanism: the returner sends this TideLink's total
                free credit count to the paired TideLink's doorbell response
                accumulator (pair offset 0x024).";

        field {} trigger[1] = 0;
        trigger->sw = w;
        trigger->hw = r;
        trigger->singlepulse;
    };
    doorbell_reg doorbell @ 0x014;

    reg release_acc_reg {
        name = "Release Accumulator";
        desc = "Read-only debug register. Shows the number of credits that have
                been freed by packet reads but not yet released to the paired
                TideLink (i.e. accumulated below the release threshold). Cleared
                to zero when the release threshold is crossed and the returner
                fires.";

        field {} acc[32] = 0;
        acc->sw = r;
        acc->hw = w;
    };
    release_acc_reg release_acc @ 0x018;

    reg ctrl_reg {
        name = "Control Register";
        desc = "Block enable and flush control. FLUSH is self-clearing and
                only takes effect when EN is 0.";

        field {} en[1] = 0;
        en->sw = rw;
        en->hw = r;
        en->desc = "Block enable. When 0, AHB data window accesses are gated
                    (transfers ignored). APB registers and master port remain
                    functional.";

        field {} flush[1] = 0;
        flush->sw = rw;
        flush->hw = r;
        flush->singlepulse;
        flush->desc = "Write 1 to reset write/read pointers, packet counter,
                      length-prepend parser, release accumulator, and sticky
                      fault flags (OVERRUN, UNDERRUN, MASTER_ERROR). Self-clearing.
                      EN must be 0 before flushing.";
    };
    ctrl_reg ctrl @ 0x01C;

    // =========================================================================
    // Region 1: Incoming Credit Receivers (paddr[5] = 1)
    // =========================================================================

    reg accumulator_reg {
        name = "Credit Accumulator";
        desc = "Write-to-add / Read-to-clear accumulator.
                Hardware (bus fabric) writes ADD the value to the running total.
                Software reads return the accumulated total, then the register
                is cleared to zero. The associated IRQ deasserts on clear.
                NOTE: The write-accumulate and read-clear behaviour is custom
                and not expressible in standard SystemRDL access types.";

        field {} acc[32] = 0;
        acc->sw   = rw;
        acc->hw   = rw;
        acc->rclr;
    };

    accumulator_reg released_credits_acc @ 0x020;
    released_credits_acc->name = "Released Credits Accumulator";
    released_credits_acc->desc = "Receives channel-0 delta values from the paired TideLink's
                                 returner. Each write adds to the accumulator. A CPU read
                                 returns the total and clears it. IRQ: released_credits_irq.";

    accumulator_reg doorbell_response_acc @ 0x024;
    doorbell_response_acc->name = "Doorbell Response Accumulator";
    doorbell_response_acc->desc = "Receives channel-1 total-credit values from the paired
                                   TideLink's returner (doorbell responses). Each write adds
                                   to the accumulator. A CPU read returns the total and clears
                                   it. IRQ: doorbell_irq.";

    reg pair_credit_counter_reg {
        name = "Pair Credit Counter";
        desc = "Running count of available credits on the paired TideLink side.
                Automatically incremented when a value is written to the
                Released Credits Accumulator (0x020). Decremented by CPU writes
                to the Pair Credit Consume register (0x02C). Read-only from the
                CPU perspective (read without side effects). Gated by the
                Pair Credit Counter Enable register.";

        field {} count[32] = 0;
        count->sw = r;
        count->hw = rw;
    };
    pair_credit_counter_reg pair_credit_counter @ 0x028;

    reg pair_credit_consume_reg {
        name = "Pair Credit Consume";
        desc = "Write-only. CPU writes the number of credits being consumed.
                The value is subtracted from the Pair Credit Counter (0x028).
                Only effective when the Pair Credit Counter Enable is set.";

        field {} consume[32] = 0;
        consume->sw = w;
        consume->hw = r;
    };
    pair_credit_consume_reg pair_credit_consume @ 0x02C;

    reg pair_credit_counter_en_reg {
        name = "Pair Credit Counter Enable";
        desc = "Bit 0 controls whether the Pair Credit Counter (0x028) is
                updated. Default is enabled (1). When disabled (0), the
                counter freezes and ignores increment/decrement events.";

        field {} enable[1] = 1;
        enable->sw = rw;
        enable->hw = r;
    };
    pair_credit_counter_en_reg pair_credit_counter_en @ 0x030;

    // =========================================================================
    // Region 4: Chiplet Controller Role Configuration (paddr[7:5] = 100)
    //   Accessible via tidelink_apb_regs Region 4 pass-through to
    //   axi_chiplet_controller role register block.
    //   These registers are reset only by poresetn (survive warm hresetn).
    // =========================================================================

    reg role_cfg_reg {
        name = "Role Configuration";
        desc = "Selects chiplet controller role (master or slave) and locks
                the selection. The role must be locked before the Wlink link
                can train. Once locked, only a full power-on reset (poresetn)
                can change the role.
                Before lock: role defaults to the role_strap_i pin value.
                After lock: role is frozen to the register value.";

        field {} role[1] = 0;
        role->sw = rw;
        role->hw = r;
        role->desc = "0 = master (I2C bus master, APB direct to Wlink).
                      1 = slave (I2C bus slave, remote master configures Wlink).
                      Only writable while role_lock == 0.";

        field {} role_lock[1] = 0;
        role_lock->sw = rw;
        role_lock->hw = r;
        role_lock->desc = "Write-1-to-set (W1S). Once set, the role field is
                           frozen and Wlink POR is released, allowing link
                           training to begin. Cleared only by poresetn.";
    };
    role_cfg_reg role_cfg @ 0x080;

    reg role_status_reg {
        name = "Role Status";
        desc = "Read-only view of the current role state and I2C slave status.";

        field {} effective_role[1] = 0;
        effective_role->sw = r;
        effective_role->hw = w;
        effective_role->desc = "Current effective role: 0=master, 1=slave.
                                Before lock: reflects role_strap_i.
                                After lock: reflects role_cfg.role.";

        field {} locked[1] = 0;
        locked->sw = r;
        locked->hw = w;
        locked->desc = "1 when role_lock has been set. Wlink is active.";

        field {} i2c_busy[1] = 0;
        i2c_busy->sw = r;
        i2c_busy->hw = w;
        i2c_busy->desc = "I2C slave core busy flag (slave mode only).";

        field {} i2c_addressed[1] = 0;
        i2c_addressed->sw = r;
        i2c_addressed->hw = w;
        i2c_addressed->desc = "I2C slave has been addressed on the bus.";
    };
    role_status_reg role_status @ 0x084;

    reg i2c_slv_addr_reg {
        name = "I2C Slave Address";
        desc = "7-bit I2C device address for the slave core. Only effective
                in slave mode. Can be written before or after role lock.";

        field {} device_addr[7] = 0;
        device_addr->sw = rw;
        device_addr->hw = r;
    };
    i2c_slv_addr_reg i2c_slv_addr @ 0x088;

    reg i2c_prescale_reg {
        name = "I2C Master Prescale";
        desc = "16-bit clock prescaler for the I2C master core. Sets the
                SCL frequency: f_SCL = f_CLK / (4 * prescale). Only
                effective in master mode. Can be written before or after
                role lock.";

        field {} prescale[16] = 1;
        prescale->sw = rw;
        prescale->hw = r;
    };
    i2c_prescale_reg i2c_prescale @ 0x08C;

    // =========================================================================
    // Region 4 (continued): Auto-negotiation control (paddr[7:5]=100, slot[4:7])
    // (Existing registers — no change from current chiplet-controller layout
    //  in axi_chiplet_controller.sv:419-422; declared here for RDL parity.)
    // =========================================================================

    reg nego_cfg_reg {
        name = "Auto-Negotiation Configuration";
        desc = "Configuration bits for the autoneg FSM.
                bit[0] = nego_en, bit[6] = mask_hs_auto_en.";
        field {} cfg[7] = 0;
        cfg->sw = rw;
        cfg->hw = r;
    };
    nego_cfg_reg nego_cfg @ 0x090;

    reg nego_status_reg {
        name = "Auto-Negotiation Status";
        desc = "Live status of the autoneg FSM. Read-only.";
        field {} state[4] = 0;
        state->sw = r;
        state->hw = w;
        field {} done[1] = 0;
        done->sw = r;
        done->hw = w;
        field {} error[1] = 0;
        error->sw = r;
        error->hw = w;
        field {} won[1] = 0;
        won->sw = r;
        won->hw = w;
        field {} lost[1] = 0;
        lost->sw = r;
        lost->hw = w;
        field {} sda_start_seen[1] = 0;
        sda_start_seen->sw = r;
        sda_start_seen->hw = w;
        field {} mask_mismatch[1] = 0;
        mask_mismatch->sw = r;
        mask_mismatch->hw = w;
    };
    nego_status_reg nego_status @ 0x094;

    reg nego_priority_reg {
        name = "Auto-Negotiation Priority";
        desc = "16-bit priority value sent during NEGO_CLAIM. Lower wins.";
        field {} priority_value[16] = 16'hFFFF;
        priority_value->sw = rw;
        priority_value->hw = r;
    };
    nego_priority_reg nego_priority @ 0x098;

    reg nego_timeout_reg {
        name = "Auto-Negotiation Timeout";
        desc = "Cycle-count timeout for the autoneg FSM.";
        field {} timeout[32] = 32'd131_082_000;
        timeout->sw = rw;
        timeout->hw = r;
    };
    nego_timeout_reg nego_timeout @ 0x09C;

    // =========================================================================
    // Region 8: Chiplet Extended -- PHY Alignment & I2C Training
    //   paddr[8:5] = 4'b1000, offsets 0x100..0x11F.
    //   Decoded by a 4-bit region select (paddr[8:5]); existing Regions 0..7
    //   keep their 3-bit decode (paddr[7:5] with paddr[8]=0).
    //   See staging/apb_redesign/PROPOSAL.md for full design rationale.
    // =========================================================================

    reg swi_training_mode_reg {
        name = "SWI Training Mode";
        desc = "Drives the Wlink GPIO PHY's training pattern + lane-checker
                enable. Writable from both local APB and the I2C-slave AXIL
                bridge (peer-driven). POR-only reset domain (survives warm
                hresetn so training state persists across system reset).";
        field {} swi_training_mode[1] = 0;
        swi_training_mode->sw = rw;
        swi_training_mode->hw = r;
        swi_training_mode->desc = "1 = TX serialiser emits per-lane training
                                    pattern; lane-checker FSM evaluates;
                                    LL TX/RX held off via swi_lltx/llrx gating.";
    };
    swi_training_mode_reg swi_training_mode @ 0x100;

    reg swi_bit_slip_lo_reg {
        name = "SWI Bit Slip (Low)";
        desc = "Per-lane bit-slip for the 8 PHY RX lanes, packed 3 bits per
                lane (lane K at bits [3K+2:3K]). SW override of the
                autonomous calibration FSM's per-lane slip value.";
        field {} bit_slip[24] = 0;
        bit_slip->sw = rw;
        bit_slip->hw = r;
        bit_slip->desc = "8 lanes x 3-bit right-rotation amount.";
    };
    swi_bit_slip_lo_reg swi_bit_slip_lo @ 0x104;

    reg swi_lane_status_reg {
        name = "SWI Lane Status";
        desc = "Read-only per-lane lock + fault + calibration done status.
                Packed so an I2C 4-byte read captures all three signals in
                one transaction (byte 0 = lane_locked, byte 1 = lane_fault,
                byte 2 = calibration_done, byte 3 = reserved).";
        field {} lane_locked[8] = 0;
        lane_locked->sw = r;
        lane_locked->hw = w;
        lane_locked->desc = "Per-lane lock status from the wlink_lane_checker.";
        field {} lane_fault[8] = 0;
        lane_fault->sw = r;
        lane_fault->hw = w;
        lane_fault->desc = "Per-lane sticky fault from the cal FSM.";
        field {} calibration_done[1] = 0;
        calibration_done->sw = r;
        calibration_done->hw = w;
        calibration_done->desc = "Set by the cal FSM at convergence.";
    };
    swi_lane_status_reg swi_lane_status @ 0x108;

    reg nego_train_cfg_reg {
        name = "Nego Train Configuration";
        desc = "I2C-coordinated training-mode handshake configuration.";
        field {} train_auto_en[1] = 0;
        train_auto_en->sw = rw;
        train_auto_en->hw = r;
        field {} train_sw_step[1] = 0;
        train_sw_step->sw = rw;
        train_sw_step->hw = r;
        field {} train_retrain[1] = 0;
        train_retrain->sw = rw;
        train_retrain->hw = r;
        train_retrain->singlepulse;
        field {} train_poll_timeout[4] = 0;
        train_poll_timeout->sw = rw;
        train_poll_timeout->hw = r;
        field {} train_fsm_wait_hi[8] = 0;
        train_fsm_wait_hi->sw = rw;
        train_fsm_wait_hi->hw = r;
    };
    nego_train_cfg_reg nego_train_cfg @ 0x10C;

    reg nego_train_status_reg {
        name = "Nego Train Status";
        desc = "Live status of the training sub-flow + last-captured peer
                fault/lock values.";
        field {} train_ok[1] = 0;
        train_ok->sw = r;
        train_ok->hw = w;
        field {} train_fail[1] = 0;
        train_fail->sw = r;
        train_fail->hw = w;
        field {} train_in_progress[1] = 0;
        train_in_progress->sw = r;
        train_in_progress->hw = w;
        field {} train_peer_nack[1] = 0;
        train_peer_nack->sw = r;
        train_peer_nack->hw = w;
        field {} train_state[4] = 0;
        train_state->sw = r;
        train_state->hw = w;
        field {} train_peer_lane_locked[8] = 0;
        train_peer_lane_locked->sw = r;
        train_peer_lane_locked->hw = w;
        field {} train_peer_lane_fault[8] = 0;
        train_peer_lane_fault->sw = r;
        train_peer_lane_fault->hw = w;
    };
    nego_train_status_reg nego_train_status @ 0x110;

    reg nego_train_step_reg {
        name = "Nego Train Step";
        desc = "W1P single-step pulse for debug.";
        field {} step[1] = 0;
        step->sw = rw;
        step->hw = r;
        step->singlepulse;
    };
    nego_train_step_reg nego_train_step @ 0x114;

    reg swi_bit_slip_hi_reg {
        name = "SWI Bit Slip (High) -- reserved";
        desc = "Reserved for future 16-lane PHY builds.";
        field {} bit_slip_hi[24] = 0;
        bit_slip_hi->sw = rw;
        bit_slip_hi->hw = r;
    };
    swi_bit_slip_hi_reg swi_bit_slip_hi @ 0x118;

    reg phy_align_id_reg {
        name = "PHY Alignment Block ID";
        desc = "Read-only identification. 0x5041_0100 = 'PA' v1.0.";
        field {} id[32] = 32'h50410100;
        id->sw = r;
        id->hw = na;
    };
    phy_align_id_reg phy_align_id @ 0x11C;
};
